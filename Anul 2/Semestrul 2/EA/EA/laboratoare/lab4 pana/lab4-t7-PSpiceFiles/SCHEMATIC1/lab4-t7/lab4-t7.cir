** Profile: "SCHEMATIC1-lab4-t7"  [ C:\Users\yoyol\Desktop\Facultate\lab4-t7-PSpiceFiles\SCHEMATIC1\lab4-t7.sim ]

** Creating circuit file "lab4-t7.cir"
** WARNING: THIS AUTOMATICALLY GENERATED FILE MAY BE OVERWRITTEN BY SUBSEQUENT SIMULATIONS

*Libraries:
* Profile Libraries :
* Local Libraries :
* From [PSPICE NETLIST] section of C:\Users\yoyol\AppData\Roaming\SPB_Data\cdssetup\OrCAD_PSpice\17.2.0\PSpice.ini file:
.lib "nomd.lib"

*Analysis directives:
.DC LIN V_V3 -200m 200m 0.1m
.OPTIONS ADVCONV
.PROBE64 V(alias(*)) I(alias(*)) W(alias(*)) D(alias(*)) NOISE(alias(*))
.INC "..\SCHEMATIC1.net"

.END
